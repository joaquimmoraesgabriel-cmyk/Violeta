* Bancada bidirecional; degraus e carga oscilante.
.include atuadores_candidatos.inc
.param caso=0
.param margem_limite=table(caso,0,9e-05,1,9e-05,2,9e-05,3,9.5e-05,4,9.5e-05,5,9.5e-05)
.param gbw_limit=table(caso,0,20000000.0,1,100000000.0,2,200000000.0,3,20000000.0,4,100000000.0,5,200000000.0)
.step param caso 0 5 1
Vp vp 0 5
Vm vm 0 -5
VloadY y 0 SINE(0 1.4 1000)
VloadX x 0 SINE(0 1.2 730)
VpedidoY pedido_y 0 PWL(0 0 20u 0 20.1u 40u 70u 40u 70.1u 250u 130u 250u 130.1u -250u 190u -250u 190.1u 0 230u 0 230.1u 80u 290u 80u 290.1u -80u 350u -80u 350.1u 0)
VpedidoX pedido_x 0 PWL(0 0 20u 0 20.1u 40u 70u 40u 70.1u 250u 130u 250u 130.1u 250u 190u 250u 190.1u 0 230u 0 230.1u 10u 290u 10u 290.1u -10u 350u -10u 350.1u 0)
BcmdY cmd_y 0 V={V(pedido_y)*V(ganho)}
BcmdX cmd_x 0 V={V(pedido_x)*V(ganho)}
XY cmd_y y vp vm med_y ATUADOR
XX cmd_x x vp vm med_x ATUADOR
XL med_y med_x vp vm ganho LIMITADOR
Btotal total 0 V={abs(V(med_y))+abs(V(med_x))}
.save V(total) V(ganho) V(med_y) V(med_x) I(VloadY) I(VloadX)
.tran 0 400u 0 100n uic
.meas tran pico MAX V(total) FROM 0 TO 400u
.meas tran patamar AVG V(total) FROM 95u TO 125u
.options plotwinsize=0 reltol=1e-6 vntol=1e-9 abstol=1e-12 threads=1
.end
