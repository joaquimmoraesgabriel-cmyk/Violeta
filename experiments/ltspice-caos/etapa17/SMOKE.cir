* C_comum_f0
.include MLC_coordenador_E.inc
Va entrada_a 0 PWL(0.000000 0 0.050000 0 0.050001 0 0.100000 0 0.100001 0 0.150000 0 0.150001 0 0.200000 0 0.200001 1 0.250000 1 0.250001 0 0.300000 0 0.300001 1 0.350000 1 0.350001 0 0.400000 0 0.400001 0 0.450000 0 0.450001 1 0.500000 1 0.500001 0 0.550000 0 0.550001 1 0.600000 1 0.600001 1 0.650000 1 0.650001 1 0.700000 1 0.700001 1 0.750000 1 0.750001 1 0.800000 1 0.800001 0 0.850000 0)
Vb entrada_b 0 PWL(0.000000 0 0.050000 0 0.050001 0 0.100000 0 0.100001 1 0.150000 1 0.150001 0 0.200000 0 0.200001 0 0.250000 0 0.250001 0 0.300000 0 0.300001 1 0.350000 1 0.350001 1 0.400000 1 0.400001 1 0.450000 1 0.450001 0 0.500000 0 0.500001 1 0.550000 1 0.550001 1 0.600000 1 0.600001 0 0.650000 0 0.650001 0 0.700000 0 0.700001 1 0.750000 1 0.750001 1 0.800000 1 0.800001 0 0.850000 0)
.param caso=0
.param perfil=table(caso,0,3,1,3,2,3,3,3)
.param topologia=table(caso,0,15,1,15,2,15,3,15)
.param politica_coord=table(caso,0,0,1,0,2,0,3,0)
.param falha_coord=table(caso,0,0,1,0,2,0,3,0)
.param amp_a=table(caso,0,0.006,1,0.006,2,0.006,3,0.006)
.param amp_b=table(caso,0,0.009,1,0.009,2,0.009,3,0.009)
.param amp_c=table(caso,0,0.007,1,0.007,2,0.007,3,0.007)
.param amp_d=table(caso,0,0.008,1,0.008,2,0.008,3,0.008)
.param x_inicial=table(caso,0,-0.37,1,0.37,2,-0.37,3,0.37)
.param y_inicial=table(caso,0,-0.2,1,-0.2,2,-0.2,3,-0.2)
.param passo=table(caso,0,1.25e-06,1,1.25e-06,2,6.25e-07,3,6.25e-07)
.param detector=table(caso,0,1,1,1,2,1,3,1)
.param cap_operacao=table(caso,0,9e-05,1,9e-05,2,9e-05,3,9e-05)
.param hardware=table(caso,0,1,1,1,2,1,3,1)
.param lat_s=table(caso,0,5e-05,1,5e-05,2,5e-05,3,5e-05)
.param tau_s=table(caso,0,0.0001,1,0.0001,2,0.0001,3,0.0001)
.param esc_erro=table(caso,0,1,1,1,2,1,3,1)
.param modo_e=table(caso,0,2,1,2,2,2,3,2)
.param cap_e=table(caso,0,5e-06,1,5e-06,2,5e-06,3,5e-06)
.param falhas_e=table(caso,0,0,1,0,2,0,3,0)
.param erro_comum_e=table(caso,0,0,1,0,2,0,3,0)
.param arquitetura=table(caso,0,0,1,0,2,0,3,0)
.param lat_coord=table(caso,0,2e-05,1,2e-05,2,2e-05,3,2e-05)
.param tau_coord=table(caso,0,5e-05,1,5e-05,2,5e-05,3,5e-05)
.param falha_super=table(caso,0,0,1,0,2,0,3,0)
.param alvo_topo=table(caso,0,0,1,0,2,0,3,0)
.step param caso 0 1 1
.save V(x) V(saida) V(orcamento)
.save V(sem_protecao) V(guard_ativo) V(reserva_ativa) V(sobra) V(falta)
.save V(y) V(referencia) V(ler) V(reserva_ativa) V(trip) V(timer) V(discrepancia) V(limiar)
.save V(esperado_y) V(esperado_d) V(med_y) V(med_d) V(comando_y) V(comando_d) V(ganho_fisico) V(habilitado)
.save V(xy:entrada_shunt) V(xd:entrada_shunt) V(br_y) V(br_d) I(XY:Rshunt) I(XD:Rshunt) I(Vsensey) I(Vsensed)
.save V(demanda_y) V(demanda_d) V(ajuste_d) V(pert_d)
.save V(esperado_e) V(med_e) V(comando_e) V(xe:entrada_shunt) V(br_e) I(XE:Rshunt) I(Vsensee)
.save V(ajuste_e) V(estimativa_e) V(deficit_d) V(base_d)
.save V(quota_y) V(quota_d) V(q_msg_y) V(q_msg_d) V(quota_invalida) V(hb_quota)
.save V(frac_alvo) V(frac_recebida) V(base_y) V(saldo_concedido)
.tran 0 0.001 0 {passo} uic
.end
