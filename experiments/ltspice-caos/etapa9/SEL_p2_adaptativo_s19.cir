* Selecao causal; replicas favoraveis, despertar e ruido definidos.
.include MLC_seletivo.inc
.include SEL_p2_adaptativo_s19_sinais.inc
Va entrada_a 0 PWL(0.000000 0 0.050000 0 0.050001 0 0.100000 0 0.100001 0 0.150000 0 0.150001 0 0.200000 0 0.200001 1 0.250000 1 0.250001 0 0.300000 0 0.300001 1 0.350000 1 0.350001 0 0.400000 0 0.400001 0 0.450000 0 0.450001 1 0.500000 1 0.500001 0 0.550000 0 0.550001 1 0.600000 1 0.600001 1 0.650000 1 0.650001 1 0.700000 1 0.700001 1 0.750000 1 0.750001 1 0.800000 1 0.800001 0 0.850000 0)
Vb entrada_b 0 PWL(0.000000 0 0.050000 0 0.050001 0 0.100000 0 0.100001 1 0.150000 1 0.150001 0 0.200000 0 0.200001 0 0.250000 0 0.250001 0 0.300000 0 0.300001 1 0.350000 1 0.350001 1 0.400000 1 0.400001 1 0.450000 1 0.450001 0 0.500000 0 0.500001 1 0.550000 1 0.550001 1 0.600000 1 0.600001 0 0.650000 0 0.650001 0 0.700000 0 0.700001 1 0.750000 1 0.750001 1 0.800000 1 0.800001 0 0.850000 0)
.param perfil=1 politica=2 atraso_coord=0 orcamento_max=100u
.param x_inicial=if(inicial,0.37,-0.37) y_inicial=-0.2 passo=5u
.step param inicial list 0 1
.save V(x) V(saida) V(referencia) V(ler) V(ativos) V(validos) V(estimativa_b) V(orcamento)
.tran 0 0.85 0 {passo} uic
.meas tran minimo_00 MIN V(x) FROM 0.030000 TO 0.049000
.meas tran maximo_00 MAX V(x) FROM 0.030000 TO 0.049000
.meas tran minimo_01 MIN V(x) FROM 0.080000 TO 0.099000
.meas tran maximo_01 MAX V(x) FROM 0.080000 TO 0.099000
.meas tran minimo_02 MIN V(x) FROM 0.130000 TO 0.149000
.meas tran maximo_02 MAX V(x) FROM 0.130000 TO 0.149000
.meas tran minimo_03 MIN V(x) FROM 0.180000 TO 0.199000
.meas tran maximo_03 MAX V(x) FROM 0.180000 TO 0.199000
.meas tran minimo_04 MIN V(x) FROM 0.230000 TO 0.249000
.meas tran maximo_04 MAX V(x) FROM 0.230000 TO 0.249000
.meas tran minimo_05 MIN V(x) FROM 0.280000 TO 0.299000
.meas tran maximo_05 MAX V(x) FROM 0.280000 TO 0.299000
.meas tran minimo_06 MIN V(x) FROM 0.330000 TO 0.349000
.meas tran maximo_06 MAX V(x) FROM 0.330000 TO 0.349000
.meas tran minimo_07 MIN V(x) FROM 0.380000 TO 0.399000
.meas tran maximo_07 MAX V(x) FROM 0.380000 TO 0.399000
.meas tran minimo_08 MIN V(x) FROM 0.430000 TO 0.449000
.meas tran maximo_08 MAX V(x) FROM 0.430000 TO 0.449000
.meas tran minimo_09 MIN V(x) FROM 0.480000 TO 0.499000
.meas tran maximo_09 MAX V(x) FROM 0.480000 TO 0.499000
.meas tran minimo_10 MIN V(x) FROM 0.530000 TO 0.549000
.meas tran maximo_10 MAX V(x) FROM 0.530000 TO 0.549000
.meas tran minimo_11 MIN V(x) FROM 0.580000 TO 0.599000
.meas tran maximo_11 MAX V(x) FROM 0.580000 TO 0.599000
.meas tran minimo_12 MIN V(x) FROM 0.630000 TO 0.649000
.meas tran maximo_12 MAX V(x) FROM 0.630000 TO 0.649000
.meas tran minimo_13 MIN V(x) FROM 0.680000 TO 0.699000
.meas tran maximo_13 MAX V(x) FROM 0.680000 TO 0.699000
.meas tran minimo_14 MIN V(x) FROM 0.730000 TO 0.749000
.meas tran maximo_14 MAX V(x) FROM 0.730000 TO 0.749000
.meas tran minimo_15 MIN V(x) FROM 0.780000 TO 0.799000
.meas tran maximo_15 MAX V(x) FROM 0.780000 TO 0.799000
.meas tran minimo_16 MIN V(x) FROM 0.830000 TO 0.849000
.meas tran maximo_16 MAX V(x) FROM 0.830000 TO 0.849000
.meas tran pico_orcamento MAX V(orcamento) FROM 0 TO 0.85
.end
