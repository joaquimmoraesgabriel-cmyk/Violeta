* L2_1_2
.include MLC_cotas_v1.inc
Va entrada_a 0 PWL(0.000000 0 0.050000 0 0.050001 0 0.100000 0 0.100001 0 0.150000 0 0.150001 0 0.200000 0 0.200001 1 0.250000 1 0.250001 0 0.300000 0 0.300001 1 0.350000 1 0.350001 0 0.400000 0 0.400001 0 0.450000 0 0.450001 1 0.500000 1 0.500001 0 0.550000 0 0.550001 1 0.600000 1 0.600001 1 0.650000 1 0.650001 1 0.700000 1 0.700001 1 0.750000 1 0.750001 1 0.800000 1 0.800001 0 0.850000 0)
Vb entrada_b 0 PWL(0.000000 0 0.050000 0 0.050001 0 0.100000 0 0.100001 1 0.150000 1 0.150001 0 0.200000 0 0.200001 0 0.250000 0 0.250001 0 0.300000 0 0.300001 1 0.350000 1 0.350001 1 0.400000 1 0.400001 1 0.450000 1 0.450001 0 0.500000 0 0.500001 1 0.550000 1 0.550001 1 0.600000 1 0.600001 0 0.650000 0 0.650001 0 0.700000 0 0.700001 1 0.750000 1 0.750001 1 0.800000 1 0.800001 0 0.850000 0)
.param caso=0
.param perfil=table(caso,0,3,1,3,2,3,3,3)
.param topologia=table(caso,0,15,1,15,2,15,3,15)
.param politica_coord=table(caso,0,0,1,0,2,0,3,0)
.param falha_coord=table(caso,0,0,1,0,2,0,3,0)
.param amp_a=table(caso,0,0.006,1,0.006,2,0.006,3,0.006)
.param amp_b=table(caso,0,0.009,1,0.009,2,0.009,3,0.009)
.param amp_c=table(caso,0,0.007,1,0.007,2,0.007,3,0.007)
.param amp_d=table(caso,0,0.008,1,0.008,2,0.008,3,0.008)
.param x_inicial=table(caso,0,-0.37,1,0.37,2,-0.37,3,0.37)
.param y_inicial=table(caso,0,-0.2,1,-0.2,2,-0.2,3,-0.2)
.param passo=table(caso,0,1.25e-06,1,1.25e-06,2,6.25e-07,3,6.25e-07)
.param detector=table(caso,0,1,1,1,2,1,3,1)
.param cap_operacao=table(caso,0,9e-05,1,9e-05,2,9e-05,3,9e-05)
.param hardware=table(caso,0,1,1,1,2,1,3,1)
.param lat_s=table(caso,0,5e-05,1,5e-05,2,5e-05,3,5e-05)
.param tau_s=table(caso,0,0.0001,1,0.0001,2,0.0001,3,0.0001)
.param esc_erro=table(caso,0,1,1,1,2,1,3,1)
.param modo_e=table(caso,0,2,1,2,2,2,3,2)
.param cap_e=table(caso,0,5e-06,1,5e-06,2,5e-06,3,5e-06)
.param falhas_e=table(caso,0,0,1,0,2,0,3,0)
.param erro_comum_e=table(caso,0,0,1,0,2,0,3,0)
.param arquitetura=table(caso,0,0,1,0,2,0,3,0)
.param lat_coord=table(caso,0,1e-06,1,1e-06,2,1e-06,3,1e-06)
.param tau_coord=table(caso,0,2e-06,1,2e-06,2,2e-06,3,2e-06)
.param falha_super=table(caso,0,0,1,0,2,0,3,0)
.param alvo_topo=table(caso,0,0,1,0,2,0,3,0)
.param politica_l2=table(caso,0,1,1,1,2,1,3,1)
.param diagnostico_cotas=table(caso,0,1,1,1,2,1,3,1)
.param lat_ref_extra=table(caso,0,2e-06,1,2e-06,2,2e-06,3,2e-06)
.param tol_ref=table(caso,0,0.05,1,0.05,2,0.05,3,0.05)
.param offset_q=table(caso,0,5e-07,1,5e-07,2,5e-07,3,5e-07)
.param ruido_q=table(caso,0,5e-07,1,5e-07,2,5e-07,3,5e-07)
.param drift_ppm=table(caso,0,0,1,0,2,0,3,0)
.param clock_offset=table(caso,0,0,1,0,2,0,3,0)
.step param caso 0 3 1
.save V(x) V(saida) V(orcamento)
.save V(sem_protecao) V(guard_ativo) V(reserva_ativa) V(sobra) V(falta)
.save V(y) V(referencia) V(ler) V(reserva_ativa) V(trip) V(timer) V(discrepancia) V(limiar)
.save V(esperado_y) V(esperado_d) V(med_y) V(med_d) V(comando_y) V(comando_d) V(ganho_fisico) V(habilitado)
.save V(xy:entrada_shunt) V(xd:entrada_shunt) V(br_y) V(br_d) I(XY:Rshunt) I(XD:Rshunt) I(Vsensey) I(Vsensed)
.save V(demanda_y) V(demanda_d) V(ajuste_d) V(pert_d)
.save V(esperado_e) V(med_e) V(comando_e) V(xe:entrada_shunt) V(br_e) I(XE:Rshunt) I(Vsensee)
.save V(ajuste_e) V(estimativa_e) V(deficit_d) V(base_d)
.save V(quota_y) V(quota_d) V(q_msg_y) V(q_msg_d) V(quota_invalida)
.save V(idade_cota) V(idade_invalida) V(erro_cota) V(incoerente) V(trip_cota) V(reserva_cota)
.save V(timer_cota) V(saldo_concedido)
.tran 0 0.85 0 {passo} uic
.meas tran minimo_00 MIN V(x) FROM 0.030000 TO 0.049000
.meas tran maximo_00 MAX V(x) FROM 0.030000 TO 0.049000
.meas tran minimo_01 MIN V(x) FROM 0.080000 TO 0.099000
.meas tran maximo_01 MAX V(x) FROM 0.080000 TO 0.099000
.meas tran minimo_02 MIN V(x) FROM 0.130000 TO 0.149000
.meas tran maximo_02 MAX V(x) FROM 0.130000 TO 0.149000
.meas tran minimo_03 MIN V(x) FROM 0.180000 TO 0.199000
.meas tran maximo_03 MAX V(x) FROM 0.180000 TO 0.199000
.meas tran minimo_04 MIN V(x) FROM 0.230000 TO 0.249000
.meas tran maximo_04 MAX V(x) FROM 0.230000 TO 0.249000
.meas tran minimo_05 MIN V(x) FROM 0.280000 TO 0.299000
.meas tran maximo_05 MAX V(x) FROM 0.280000 TO 0.299000
.meas tran minimo_06 MIN V(x) FROM 0.330000 TO 0.349000
.meas tran maximo_06 MAX V(x) FROM 0.330000 TO 0.349000
.meas tran minimo_07 MIN V(x) FROM 0.380000 TO 0.399000
.meas tran maximo_07 MAX V(x) FROM 0.380000 TO 0.399000
.meas tran minimo_08 MIN V(x) FROM 0.430000 TO 0.449000
.meas tran maximo_08 MAX V(x) FROM 0.430000 TO 0.449000
.meas tran minimo_09 MIN V(x) FROM 0.480000 TO 0.499000
.meas tran maximo_09 MAX V(x) FROM 0.480000 TO 0.499000
.meas tran minimo_10 MIN V(x) FROM 0.530000 TO 0.549000
.meas tran maximo_10 MAX V(x) FROM 0.530000 TO 0.549000
.meas tran minimo_11 MIN V(x) FROM 0.580000 TO 0.599000
.meas tran maximo_11 MAX V(x) FROM 0.580000 TO 0.599000
.meas tran minimo_12 MIN V(x) FROM 0.630000 TO 0.649000
.meas tran maximo_12 MAX V(x) FROM 0.630000 TO 0.649000
.meas tran minimo_13 MIN V(x) FROM 0.680000 TO 0.699000
.meas tran maximo_13 MAX V(x) FROM 0.680000 TO 0.699000
.meas tran minimo_14 MIN V(x) FROM 0.730000 TO 0.749000
.meas tran maximo_14 MAX V(x) FROM 0.730000 TO 0.749000
.meas tran minimo_15 MIN V(x) FROM 0.780000 TO 0.799000
.meas tran maximo_15 MAX V(x) FROM 0.780000 TO 0.799000
.meas tran minimo_16 MIN V(x) FROM 0.830000 TO 0.849000
.meas tran maximo_16 MAX V(x) FROM 0.830000 TO 0.849000
.meas tran pico_orcamento MAX V(orcamento) FROM 0 TO 0.85
.meas tran pico_sem_protecao MAX V(sem_protecao) FROM 0 TO 0.85
.meas tran uso_protecao AVG V(guard_ativo) FROM 0 TO 0.85
.meas tran uso_reserva AVG V(reserva_ativa) FROM 0 TO 0.85
.meas tran sobra MAX V(sobra) FROM 0.03 TO 0.85
.meas tran falta MAX V(falta) FROM 0.03 TO 0.85
.end
