* MLC: validacao independente; 3 estados x 3 desvios x 2 passos.
.include MLC_base.inc
Va entrada_a 0 PWL(0 0 0.050000 0 0.050001 0 0.100000 0 0.100001 0 0.150000 0 0.150001 0 0.200000 0 0.200001 1 0.250000 1 0.250001 0 0.300000 0 0.300001 1 0.350000 1 0.350001 0 0.400000 0 0.400001 0 0.450000 0 0.450001 1 0.500000 1 0.500001 0 0.550000 0 0.550001 1 0.600000 1 0.600001 1 0.650000 1 0.650001 1 0.700000 1 0.700001 1 0.750000 1 0.750001 1 0.800000 1 0.800001 0 0.850000 0)
Vb entrada_b 0 PWL(0 0 0.050000 0 0.050001 0 0.100000 0 0.100001 1 0.150000 1 0.150001 0 0.200000 0 0.200001 0 0.250000 0 0.250001 0 0.300000 0 0.300001 1 0.350000 1 0.350001 1 0.400000 1 0.400001 1 0.450000 1 0.450001 0 0.500000 0 0.500001 1 0.550000 1 0.550001 1 0.600000 1 0.600001 0 0.650000 0 0.650001 0 0.700000 0 0.700001 1 0.750000 1 0.750001 1 0.800000 1 0.800001 0 0.850000 0)
.param y_inicial=0
.step param x_inicial list -1 0 1
.step param desvio list -0.005 0 0.005
.step param passo list 5u 2.5u
.tran 0 0.850000 0 {passo} uic
* Janela 00: A=0, B=0; descarta transicao.
.meas tran media_00 AVG V(x) FROM 0.030000 TO 0.049000
.meas tran minimo_00 MIN V(x) FROM 0.030000 TO 0.049000
.meas tran maximo_00 MAX V(x) FROM 0.030000 TO 0.049000
.meas tran positivo_00 AVG V(saida) FROM 0.030000 TO 0.049000
* Janela 01: A=0, B=0; descarta transicao.
.meas tran media_01 AVG V(x) FROM 0.080000 TO 0.099000
.meas tran minimo_01 MIN V(x) FROM 0.080000 TO 0.099000
.meas tran maximo_01 MAX V(x) FROM 0.080000 TO 0.099000
.meas tran positivo_01 AVG V(saida) FROM 0.080000 TO 0.099000
* Janela 02: A=0, B=1; descarta transicao.
.meas tran media_02 AVG V(x) FROM 0.130000 TO 0.149000
.meas tran minimo_02 MIN V(x) FROM 0.130000 TO 0.149000
.meas tran maximo_02 MAX V(x) FROM 0.130000 TO 0.149000
.meas tran positivo_02 AVG V(saida) FROM 0.130000 TO 0.149000
* Janela 03: A=0, B=0; descarta transicao.
.meas tran media_03 AVG V(x) FROM 0.180000 TO 0.199000
.meas tran minimo_03 MIN V(x) FROM 0.180000 TO 0.199000
.meas tran maximo_03 MAX V(x) FROM 0.180000 TO 0.199000
.meas tran positivo_03 AVG V(saida) FROM 0.180000 TO 0.199000
* Janela 04: A=1, B=0; descarta transicao.
.meas tran media_04 AVG V(x) FROM 0.230000 TO 0.249000
.meas tran minimo_04 MIN V(x) FROM 0.230000 TO 0.249000
.meas tran maximo_04 MAX V(x) FROM 0.230000 TO 0.249000
.meas tran positivo_04 AVG V(saida) FROM 0.230000 TO 0.249000
* Janela 05: A=0, B=0; descarta transicao.
.meas tran media_05 AVG V(x) FROM 0.280000 TO 0.299000
.meas tran minimo_05 MIN V(x) FROM 0.280000 TO 0.299000
.meas tran maximo_05 MAX V(x) FROM 0.280000 TO 0.299000
.meas tran positivo_05 AVG V(saida) FROM 0.280000 TO 0.299000
* Janela 06: A=1, B=1; descarta transicao.
.meas tran media_06 AVG V(x) FROM 0.330000 TO 0.349000
.meas tran minimo_06 MIN V(x) FROM 0.330000 TO 0.349000
.meas tran maximo_06 MAX V(x) FROM 0.330000 TO 0.349000
.meas tran positivo_06 AVG V(saida) FROM 0.330000 TO 0.349000
* Janela 07: A=0, B=1; descarta transicao.
.meas tran media_07 AVG V(x) FROM 0.380000 TO 0.399000
.meas tran minimo_07 MIN V(x) FROM 0.380000 TO 0.399000
.meas tran maximo_07 MAX V(x) FROM 0.380000 TO 0.399000
.meas tran positivo_07 AVG V(saida) FROM 0.380000 TO 0.399000
* Janela 08: A=0, B=1; descarta transicao.
.meas tran media_08 AVG V(x) FROM 0.430000 TO 0.449000
.meas tran minimo_08 MIN V(x) FROM 0.430000 TO 0.449000
.meas tran maximo_08 MAX V(x) FROM 0.430000 TO 0.449000
.meas tran positivo_08 AVG V(saida) FROM 0.430000 TO 0.449000
* Janela 09: A=1, B=0; descarta transicao.
.meas tran media_09 AVG V(x) FROM 0.480000 TO 0.499000
.meas tran minimo_09 MIN V(x) FROM 0.480000 TO 0.499000
.meas tran maximo_09 MAX V(x) FROM 0.480000 TO 0.499000
.meas tran positivo_09 AVG V(saida) FROM 0.480000 TO 0.499000
* Janela 10: A=0, B=1; descarta transicao.
.meas tran media_10 AVG V(x) FROM 0.530000 TO 0.549000
.meas tran minimo_10 MIN V(x) FROM 0.530000 TO 0.549000
.meas tran maximo_10 MAX V(x) FROM 0.530000 TO 0.549000
.meas tran positivo_10 AVG V(saida) FROM 0.530000 TO 0.549000
* Janela 11: A=1, B=1; descarta transicao.
.meas tran media_11 AVG V(x) FROM 0.580000 TO 0.599000
.meas tran minimo_11 MIN V(x) FROM 0.580000 TO 0.599000
.meas tran maximo_11 MAX V(x) FROM 0.580000 TO 0.599000
.meas tran positivo_11 AVG V(saida) FROM 0.580000 TO 0.599000
* Janela 12: A=1, B=0; descarta transicao.
.meas tran media_12 AVG V(x) FROM 0.630000 TO 0.649000
.meas tran minimo_12 MIN V(x) FROM 0.630000 TO 0.649000
.meas tran maximo_12 MAX V(x) FROM 0.630000 TO 0.649000
.meas tran positivo_12 AVG V(saida) FROM 0.630000 TO 0.649000
* Janela 13: A=1, B=0; descarta transicao.
.meas tran media_13 AVG V(x) FROM 0.680000 TO 0.699000
.meas tran minimo_13 MIN V(x) FROM 0.680000 TO 0.699000
.meas tran maximo_13 MAX V(x) FROM 0.680000 TO 0.699000
.meas tran positivo_13 AVG V(saida) FROM 0.680000 TO 0.699000
* Janela 14: A=1, B=1; descarta transicao.
.meas tran media_14 AVG V(x) FROM 0.730000 TO 0.749000
.meas tran minimo_14 MIN V(x) FROM 0.730000 TO 0.749000
.meas tran maximo_14 MAX V(x) FROM 0.730000 TO 0.749000
.meas tran positivo_14 AVG V(saida) FROM 0.730000 TO 0.749000
* Janela 15: A=1, B=1; descarta transicao.
.meas tran media_15 AVG V(x) FROM 0.780000 TO 0.799000
.meas tran minimo_15 MIN V(x) FROM 0.780000 TO 0.799000
.meas tran maximo_15 MAX V(x) FROM 0.780000 TO 0.799000
.meas tran positivo_15 AVG V(saida) FROM 0.780000 TO 0.799000
* Janela 16: A=0, B=0; descarta transicao.
.meas tran media_16 AVG V(x) FROM 0.830000 TO 0.849000
.meas tran minimo_16 MIN V(x) FROM 0.830000 TO 0.849000
.meas tran maximo_16 MAX V(x) FROM 0.830000 TO 0.849000
.meas tran positivo_16 AVG V(saida) FROM 0.830000 TO 0.849000
.end
