* MLC_D_validacao
.include MLC_quatro_pilares.inc
Va entrada_a 0 PWL(0.000000 0 0.050000 0 0.050001 0 0.100000 0 0.100001 0 0.150000 0 0.150001 0 0.200000 0 0.200001 1 0.250000 1 0.250001 0 0.300000 0 0.300001 1 0.350000 1 0.350001 0 0.400000 0 0.400001 0 0.450000 0 0.450001 1 0.500000 1 0.500001 0 0.550000 0 0.550001 1 0.600000 1 0.600001 1 0.650000 1 0.650001 1 0.700000 1 0.700001 1 0.750000 1 0.750001 1 0.800000 1 0.800001 0 0.850000 0)
Vb entrada_b 0 PWL(0.000000 0 0.050000 0 0.050001 0 0.100000 0 0.100001 1 0.150000 1 0.150001 0 0.200000 0 0.200001 0 0.250000 0 0.250001 0 0.300000 0 0.300001 1 0.350000 1 0.350001 1 0.400000 1 0.400001 1 0.450000 1 0.450001 0 0.500000 0 0.500001 1 0.550000 1 0.550001 1 0.600000 1 0.600001 0 0.650000 0 0.650001 0 0.700000 0 0.700001 1 0.750000 1 0.750001 1 0.800000 1 0.800001 0 0.850000 0)
.param caso=0
.param perfil=table(caso,0,0,1,0,2,0,3,0,4,0,5,0,6,0,7,0,8,1,9,1,10,1,11,1,12,1,13,1,14,1,15,1,16,2,17,2,18,2,19,2,20,2,21,2,22,2,23,2)
.param topologia=table(caso,0,0,1,0,2,0,3,0,4,8,5,8,6,8,7,8,8,7,9,7,10,7,11,7,12,15,13,15,14,15,15,15,16,0,17,0,18,0,19,0,20,8,21,8,22,8,23,8)
.param amp_a=table(caso,0,0,1,0,2,0,3,0,4,0,5,0,6,0,7,0,8,0.0025,9,0.0025,10,0.0025,11,0.0025,12,0.0025,13,0.0025,14,0.0025,15,0.0025,16,0,17,0,18,0,19,0,20,0,21,0,22,0,23,0)
.param amp_b=table(caso,0,0,1,0,2,0,3,0,4,0,5,0,6,0,7,0,8,0.003,9,0.003,10,0.003,11,0.003,12,0.003,13,0.003,14,0.003,15,0.003,16,0,17,0,18,0,19,0,20,0,21,0,22,0,23,0)
.param amp_c=table(caso,0,0,1,0,2,0,3,0,4,0,5,0,6,0,7,0,8,0.002,9,0.002,10,0.002,11,0.002,12,0.002,13,0.002,14,0.002,15,0.002,16,0,17,0,18,0,19,0,20,0,21,0,22,0,23,0)
.param amp_d=table(caso,0,0.004,1,0.004,2,0.004,3,0.004,4,0.004,5,0.004,6,0.004,7,0.004,8,0.004,9,0.004,10,0.004,11,0.004,12,0.004,13,0.004,14,0.004,15,0.004,16,0.01,17,0.01,18,0.01,19,0.01,20,0.01,21,0.01,22,0.01,23,0.01)
.param x_inicial=table(caso,0,-0.37,1,0.37,2,-0.37,3,0.37,4,-0.37,5,0.37,6,-0.37,7,0.37,8,-0.37,9,0.37,10,-0.37,11,0.37,12,-0.37,13,0.37,14,-0.37,15,0.37,16,-0.37,17,0.37,18,-0.37,19,0.37,20,-0.37,21,0.37,22,-0.37,23,0.37)
.param y_inicial=table(caso,0,-0.2,1,-0.2,2,-0.2,3,-0.2,4,-0.2,5,-0.2,6,-0.2,7,-0.2,8,-0.2,9,-0.2,10,-0.2,11,-0.2,12,-0.2,13,-0.2,14,-0.2,15,-0.2,16,-0.2,17,-0.2,18,-0.2,19,-0.2,20,-0.2,21,-0.2,22,-0.2,23,-0.2)
.param passo=table(caso,0,2.5e-06,1,2.5e-06,2,1.25e-06,3,1.25e-06,4,2.5e-06,5,2.5e-06,6,1.25e-06,7,1.25e-06,8,2.5e-06,9,2.5e-06,10,1.25e-06,11,1.25e-06,12,2.5e-06,13,2.5e-06,14,1.25e-06,15,1.25e-06,16,2.5e-06,17,2.5e-06,18,1.25e-06,19,1.25e-06,20,2.5e-06,21,2.5e-06,22,1.25e-06,23,1.25e-06)
.step param caso 0 23 1
.save V(x) V(saida) V(orcamento)
.tran 0 0.85 0 {passo} uic
.meas tran minimo_00 MIN V(x) FROM 0.030000 TO 0.049000
.meas tran maximo_00 MAX V(x) FROM 0.030000 TO 0.049000
.meas tran minimo_01 MIN V(x) FROM 0.080000 TO 0.099000
.meas tran maximo_01 MAX V(x) FROM 0.080000 TO 0.099000
.meas tran minimo_02 MIN V(x) FROM 0.130000 TO 0.149000
.meas tran maximo_02 MAX V(x) FROM 0.130000 TO 0.149000
.meas tran minimo_03 MIN V(x) FROM 0.180000 TO 0.199000
.meas tran maximo_03 MAX V(x) FROM 0.180000 TO 0.199000
.meas tran minimo_04 MIN V(x) FROM 0.230000 TO 0.249000
.meas tran maximo_04 MAX V(x) FROM 0.230000 TO 0.249000
.meas tran minimo_05 MIN V(x) FROM 0.280000 TO 0.299000
.meas tran maximo_05 MAX V(x) FROM 0.280000 TO 0.299000
.meas tran minimo_06 MIN V(x) FROM 0.330000 TO 0.349000
.meas tran maximo_06 MAX V(x) FROM 0.330000 TO 0.349000
.meas tran minimo_07 MIN V(x) FROM 0.380000 TO 0.399000
.meas tran maximo_07 MAX V(x) FROM 0.380000 TO 0.399000
.meas tran minimo_08 MIN V(x) FROM 0.430000 TO 0.449000
.meas tran maximo_08 MAX V(x) FROM 0.430000 TO 0.449000
.meas tran minimo_09 MIN V(x) FROM 0.480000 TO 0.499000
.meas tran maximo_09 MAX V(x) FROM 0.480000 TO 0.499000
.meas tran minimo_10 MIN V(x) FROM 0.530000 TO 0.549000
.meas tran maximo_10 MAX V(x) FROM 0.530000 TO 0.549000
.meas tran minimo_11 MIN V(x) FROM 0.580000 TO 0.599000
.meas tran maximo_11 MAX V(x) FROM 0.580000 TO 0.599000
.meas tran minimo_12 MIN V(x) FROM 0.630000 TO 0.649000
.meas tran maximo_12 MAX V(x) FROM 0.630000 TO 0.649000
.meas tran minimo_13 MIN V(x) FROM 0.680000 TO 0.699000
.meas tran maximo_13 MAX V(x) FROM 0.680000 TO 0.699000
.meas tran minimo_14 MIN V(x) FROM 0.730000 TO 0.749000
.meas tran maximo_14 MAX V(x) FROM 0.730000 TO 0.749000
.meas tran minimo_15 MIN V(x) FROM 0.780000 TO 0.799000
.meas tran maximo_15 MAX V(x) FROM 0.780000 TO 0.799000
.meas tran minimo_16 MIN V(x) FROM 0.830000 TO 0.849000
.meas tran maximo_16 MAX V(x) FROM 0.830000 TO 0.849000
.meas tran pico_orcamento MAX V(orcamento) FROM 0 TO 0.85
.end
